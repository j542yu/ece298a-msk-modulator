* NGSPICE file created from dac_5_3_parax.ext - technology: gf180mcuD

.subckt dac_5_3_parax B[0] B[1] B[2] B[3] B[4] T[0] T[1] T[2] T[3] T[4] T[5] T[6]
+ DAC_OUT VGND
X0 dac_r2r_5_bits_0/dac_sub_r2r_2.net1 B[2].t0 VGND.t32 ppolyf_u_1k r_width=2u r_length=40u
X1 dac_r2r_5_bits_0/dac_sub_r2r_2.net2 2R_21|2R22|2R_31|2R_32|2R_3 VGND.t21 ppolyf_u_1k r_width=2u r_length=40u
X2 dac_r2r_5_bits_0/dac_sub_r2r_3.net1 B[3].t0 VGND.t28 ppolyf_u_1k r_width=2u r_length=40u
X3 a_19166_8528# DAC_OUT.t7 VGND.t48 ppolyf_u_1k r_width=2u r_length=40u
X4 dac_r2r_5_bits_0/dac_sub_r2r_3.net2 2R_31|2R_32|2R_41|2R_42|2R_4 VGND.t54 ppolyf_u_1k r_width=2u r_length=40u
X5 a_19646_8528# DAC_OUT.t5 VGND.t34 ppolyf_u_1k r_width=2u r_length=40u
X6 dac_r2r_5_bits_0/dac_sub_r2r_0.net1 B[0].t0 VGND.t15 ppolyf_u_1k r_width=2u r_length=40u
X7 dac_r2r_5_bits_0/dac_sub_r2r_4.net2 DAC_OUT.t1 VGND.t17 ppolyf_u_1k r_width=2u r_length=40u
X8 a_19646_8528# T[4].t0 VGND.t31 ppolyf_u_1k r_width=2u r_length=40u
X9 a_19166_8528# T[5].t0 VGND.t33 ppolyf_u_1k r_width=2u r_length=40u
X10 dac_r2r_5_bits_0/dac_sub_r2r_2.net1 2R_11|2R_12|2R_21|2R_22|2R_2 VGND.t20 ppolyf_u_1k r_width=2u r_length=40u
X11 dac_r2r_5_bits_0/dac_sub_r2r_3.net2 2R_21|2R22|2R_31|2R_32|2R_3 VGND.t35 ppolyf_u_1k r_width=2u r_length=40u
X12 a_18686_8528# DAC_OUT.t0 VGND.t4 ppolyf_u_1k r_width=2u r_length=40u
X13 dac_r2r_5_bits_0/dac_sub_r2r_3.net1 2R_21|2R22|2R_31|2R_32|2R_3 VGND.t40 ppolyf_u_1k r_width=2u r_length=40u
X14 dac_r2r_5_bits_0/dac_sub_r2r_1.net2 2R_01|2R_02|2R_11|2R_12|2R_1 VGND.t44 ppolyf_u_1k r_width=2u r_length=40u
X15 dac_r2r_5_bits_0/dac_sub_r2r_4.net1 2R_31|2R_32|2R_41|2R_42|2R_4 VGND.t39 ppolyf_u_1k r_width=2u r_length=40u
X16 dac_r2r_5_bits_0/dac_sub_r2r_4.net1 B[4].t0 VGND.t53 ppolyf_u_1k r_width=2u r_length=40u
X17 dac_r2r_5_bits_0/dac_sub_r2r_1.net1 2R_01|2R_02|2R_11|2R_12|2R_1 VGND.t38 ppolyf_u_1k r_width=2u r_length=40u
X18 a_15326_8528# T[1].t0 VGND.t36 ppolyf_u_1k r_width=2u r_length=40u
X19 dac_r2r_5_bits_0/dac_sub_r2r_2.net2 2R_11|2R_12|2R_21|2R_22|2R_2 VGND.t52 ppolyf_u_1k r_width=2u r_length=40u
X20 a_15806_8528# T[2].t0 VGND.t51 ppolyf_u_1k r_width=2u r_length=40u
X21 a_14846_8528# DAC_OUT.t8 VGND.t50 ppolyf_u_1k r_width=2u r_length=40u
X22 dac_r2r_5_bits_0/dac_sub_r2r_0.net3 2R_01|2R_02|2R_11|2R_12|2R_1 VGND.t37 ppolyf_u_1k r_width=2u r_length=40u
X23 dac_r2r_5_bits_0/dac_sub_r2r_4.net3 2R_31|2R_32|2R_41|2R_42|2R_4 VGND.t9 ppolyf_u_1k r_width=2u r_length=40u
X24 dac_r2r_5_bits_0/dac_sub_r2r_4.net2 2R_31|2R_32|2R_41|2R_42|2R_4 VGND.t8 ppolyf_u_1k r_width=2u r_length=40u
X25 dac_r2r_5_bits_0/dac_sub_r2r_1.net3 2R_01|2R_02|2R_11|2R_12|2R_1 VGND.t3 ppolyf_u_1k r_width=2u r_length=40u
X26 VGND.t1 VGND.t2 VGND.t0 ppolyf_u_1k r_width=2u r_length=40u
X27 VGND.t26 VGND.t27 VGND.t25 ppolyf_u_1k r_width=2u r_length=40u
X28 dac_r2r_5_bits_0/dac_sub_r2r_1.net3 2R_11|2R_12|2R_21|2R_22|2R_2 VGND.t7 ppolyf_u_1k r_width=2u r_length=40u
X29 a_14846_8528# T[0].t0 VGND.t14 ppolyf_u_1k r_width=2u r_length=40u
X30 a_18686_8528# T[6].t0 VGND.t55 ppolyf_u_1k r_width=2u r_length=40u
X31 VGND.t42 VGND.t43 VGND.t41 ppolyf_u_1k r_width=2u r_length=40u
X32 2R_0G|2R_0G VGND.t13 VGND.t12 ppolyf_u_1k r_width=2u r_length=40u
X33 dac_r2r_5_bits_0/dac_sub_r2r_2.net3 2R_11|2R_12|2R_21|2R_22|2R_2 VGND.t5 ppolyf_u_1k r_width=2u r_length=40u
X34 a_15806_8528# DAC_OUT.t2 VGND.t22 ppolyf_u_1k r_width=2u r_length=40u
X35 a_15326_8528# DAC_OUT.t4 VGND.t29 ppolyf_u_1k r_width=2u r_length=40u
X36 dac_r2r_5_bits_0/dac_sub_r2r_0.net3 2R_0G|2R_01|2R_02|2R_0 VGND.t46 ppolyf_u_1k r_width=2u r_length=40u
X37 dac_r2r_5_bits_0/dac_sub_r2r_2.net3 2R_21|2R22|2R_31|2R_32|2R_3 VGND.t10 ppolyf_u_1k r_width=2u r_length=40u
X38 dac_r2r_5_bits_0/dac_sub_r2r_3.net3 2R_21|2R22|2R_31|2R_32|2R_3 VGND.t30 ppolyf_u_1k r_width=2u r_length=40u
X39 dac_r2r_5_bits_0/dac_sub_r2r_3.net3 2R_31|2R_32|2R_41|2R_42|2R_4 VGND.t23 ppolyf_u_1k r_width=2u r_length=40u
X40 dac_r2r_5_bits_0/dac_sub_r2r_0.net2 2R_01|2R_02|2R_11|2R_12|2R_1 VGND.t6 ppolyf_u_1k r_width=2u r_length=40u
X41 dac_r2r_5_bits_0/dac_sub_r2r_1.net1 B[1].t0 VGND.t49 ppolyf_u_1k r_width=2u r_length=40u
X42 dac_r2r_5_bits_0/dac_sub_r2r_4.net3 DAC_OUT.t6 VGND.t47 ppolyf_u_1k r_width=2u r_length=40u
X43 dac_r2r_5_bits_0/dac_sub_r2r_1.net2 2R_11|2R_12|2R_21|2R_22|2R_2 VGND.t18 ppolyf_u_1k r_width=2u r_length=40u
X44 2R_0G|2R_0G 2R_0G|2R_01|2R_02|2R_0 VGND.t45 ppolyf_u_1k r_width=2u r_length=40u
X45 dac_r2r_5_bits_0/dac_sub_r2r_0.net2 2R_0G|2R_01|2R_02|2R_0 VGND.t16 ppolyf_u_1k r_width=2u r_length=40u
X46 dac_r2r_5_bits_0/dac_sub_r2r_0.net1 2R_0G|2R_01|2R_02|2R_0 VGND.t11 ppolyf_u_1k r_width=2u r_length=40u
X47 a_16286_8528# T[3].t0 VGND.t19 ppolyf_u_1k r_width=2u r_length=40u
X48 a_16286_8528# DAC_OUT.t3 VGND.t24 ppolyf_u_1k r_width=2u r_length=40u
R0 B[2] B[2].t0 3.61864
R1 VGND.n5 VGND.n1 1986.2
R2 VGND.n5 VGND.n0 1986.13
R3 VGND.n3 VGND.n1 1145.67
R4 VGND.n3 VGND.n0 1145.36
R5 VGND.t55 VGND.t41 160.248
R6 VGND.t33 VGND.t55 160.248
R7 VGND.t31 VGND.t33 160.248
R8 VGND.t34 VGND.t31 160.248
R9 VGND.t48 VGND.t34 160.248
R10 VGND.t4 VGND.t48 160.248
R11 VGND.t50 VGND.t4 160.248
R12 VGND.t29 VGND.t50 160.248
R13 VGND.t22 VGND.t29 160.248
R14 VGND.t24 VGND.t22 160.248
R15 VGND.t19 VGND.t24 160.248
R16 VGND.t51 VGND.t19 160.248
R17 VGND.t36 VGND.t51 160.248
R18 VGND.t14 VGND.t36 160.248
R19 VGND.t47 VGND.t25 160.248
R20 VGND.t17 VGND.t47 160.248
R21 VGND.t53 VGND.t17 160.248
R22 VGND.t39 VGND.t53 160.248
R23 VGND.t8 VGND.t39 160.248
R24 VGND.t9 VGND.t8 160.248
R25 VGND.t23 VGND.t9 160.248
R26 VGND.t54 VGND.t23 160.248
R27 VGND.t28 VGND.t54 160.248
R28 VGND.t40 VGND.t28 160.248
R29 VGND.t35 VGND.t40 160.248
R30 VGND.t30 VGND.t35 160.248
R31 VGND.t10 VGND.t30 160.248
R32 VGND.t21 VGND.t10 160.248
R33 VGND.t32 VGND.t21 160.248
R34 VGND.t20 VGND.t32 160.248
R35 VGND.t52 VGND.t20 160.248
R36 VGND.t5 VGND.t52 160.248
R37 VGND.t7 VGND.t5 160.248
R38 VGND.t18 VGND.t7 160.248
R39 VGND.t49 VGND.t18 160.248
R40 VGND.t38 VGND.t49 160.248
R41 VGND.t44 VGND.t38 160.248
R42 VGND.t3 VGND.t44 160.248
R43 VGND.t37 VGND.t3 160.248
R44 VGND.t6 VGND.t37 160.248
R45 VGND.t15 VGND.t6 160.248
R46 VGND.t11 VGND.t15 160.248
R47 VGND.t16 VGND.t11 160.248
R48 VGND.t46 VGND.t16 160.248
R49 VGND.t45 VGND.t46 160.248
R50 VGND.t12 VGND.t45 160.248
R51 VGND.t0 VGND.t12 160.248
R52 VGND.n4 VGND.t14 158.911
R53 VGND.t41 VGND.n3 125.585
R54 VGND.n5 VGND.t0 125.585
R55 VGND.n2 VGND.t42 12.255
R56 VGND.n2 VGND.t43 12.255
R57 VGND.n6 VGND.t1 12.255
R58 VGND.n8 VGND.n6 7.78354
R59 VGND.n0 VGND.t26 5.30454
R60 VGND.n1 VGND.t27 4.87122
R61 VGND.n7 VGND.t13 4.50913
R62 VGND.n7 VGND.t2 3.57
R63 VGND.n4 VGND.n0 1.73383
R64 VGND.t25 VGND.n4 1.33589
R65 VGND.n4 VGND.n1 1.3005
R66 VGND.n8 VGND.n7 0.700561
R67 VGND VGND.n8 0.475045
R68 VGND.n3 VGND.n2 0.0582778
R69 VGND.n6 VGND.n5 0.0582778
R70 B[3] B[3].t0 3.61734
R71 DAC_OUT.n0 DAC_OUT.t5 4.50913
R72 DAC_OUT.n8 DAC_OUT.t6 3.61803
R73 DAC_OUT DAC_OUT.t3 3.58655
R74 DAC_OUT.n5 DAC_OUT.t2 3.57
R75 DAC_OUT.n3 DAC_OUT.t4 3.57
R76 DAC_OUT.n2 DAC_OUT.t8 3.57
R77 DAC_OUT.n1 DAC_OUT.t0 3.57
R78 DAC_OUT.n0 DAC_OUT.t7 3.57
R79 DAC_OUT.n9 DAC_OUT.t1 3.57
R80 DAC_OUT.n4 DAC_OUT 1.13724
R81 DAC_OUT.n1 DAC_OUT.n0 0.93963
R82 DAC_OUT.n3 DAC_OUT.n2 0.93963
R83 DAC_OUT.n8 DAC_OUT.n7 0.862496
R84 DAC_OUT.n4 DAC_OUT.n3 0.581587
R85 DAC_OUT.n2 DAC_OUT 0.573761
R86 DAC_OUT DAC_OUT.n1 0.36637
R87 DAC_OUT.n7 DAC_OUT 0.240307
R88 DAC_OUT.n7 DAC_OUT.n6 0.188
R89 DAC_OUT.n6 DAC_OUT.n5 0.0493341
R90 DAC_OUT.n9 DAC_OUT.n8 0.0493341
R91 DAC_OUT DAC_OUT.n9 0.0382354
R92 DAC_OUT.n5 DAC_OUT.n4 0.0374282
R93 DAC_OUT.n6 DAC_OUT 0.0319798
R94 B[0] B[0].t0 3.61864
R95 T[4] T[4].t0 3.64773
R96 T[5] T[5].t0 3.64773
R97 B[4] B[4].t0 3.61604
R98 T[1] T[1].t0 3.64773
R99 T[2] T[2].t0 3.64773
R100 T[0] T[0].t0 3.64773
R101 T[6] T[6].t0 3.64773
R102 B[1] B[1].t0 3.61864
R103 T[3] T[3].t0 3.64773
C0 T[4] DAC_OUT 0.04699f
C1 B[4] DAC_OUT 0.28314f
C2 a_15326_8528# a_19646_8528# 0
C3 dac_r2r_5_bits_0/dac_sub_r2r_3.net3 dac_r2r_5_bits_0/dac_sub_r2r_2.net3 0.15559f
C4 a_15326_8528# a_16286_8528# 0.00473f
C5 dac_r2r_5_bits_0/dac_sub_r2r_0.net1 dac_r2r_5_bits_0/dac_sub_r2r_0.net2 0.92498f
C6 a_15326_8528# a_14846_8528# 1.71136f
C7 dac_r2r_5_bits_0/dac_sub_r2r_3.net2 dac_r2r_5_bits_0/dac_sub_r2r_3.net3 1.73523f
C8 dac_r2r_5_bits_0/dac_sub_r2r_4.net1 dac_r2r_5_bits_0/dac_sub_r2r_4.net2 0.92498f
C9 dac_r2r_5_bits_0/dac_sub_r2r_1.net3 dac_r2r_5_bits_0/dac_sub_r2r_2.net3 0.15559f
C10 T[2] T[3] 0.41433f
C11 2R_11|2R_12|2R_21|2R_22|2R_2 B[2] 0.04645f
C12 T[6] T[5] 0.41433f
C13 dac_r2r_5_bits_0/dac_sub_r2r_0.net3 dac_r2r_5_bits_0/dac_sub_r2r_1.net3 0.15559f
C14 2R_11|2R_12|2R_21|2R_22|2R_2 2R_01|2R_02|2R_11|2R_12|2R_1 0
C15 a_16286_8528# a_15806_8528# 0.35649f
C16 2R_11|2R_12|2R_21|2R_22|2R_2 B[1] 0.04647f
C17 a_14846_8528# a_15806_8528# 0.0023f
C18 2R_01|2R_02|2R_11|2R_12|2R_1 B[1] 0.04645f
C19 a_18686_8528# a_19166_8528# 1.05132f
C20 DAC_OUT T[1] 0.52072f
C21 B[3] 2R_31|2R_32|2R_41|2R_42|2R_4 0.04651f
C22 dac_r2r_5_bits_0/dac_sub_r2r_0.net3 dac_r2r_5_bits_0/dac_sub_r2r_0.net2 1.73523f
C23 dac_r2r_5_bits_0/dac_sub_r2r_2.net2 dac_r2r_5_bits_0/dac_sub_r2r_2.net1 0.92498f
C24 T[0] DAC_OUT 0.54097f
C25 dac_r2r_5_bits_0/dac_sub_r2r_4.net3 dac_r2r_5_bits_0/dac_sub_r2r_4.net2 1.73523f
C26 dac_r2r_5_bits_0/dac_sub_r2r_4.net3 dac_r2r_5_bits_0/dac_sub_r2r_4.net1 0.00818f
C27 DAC_OUT 2R_31|2R_32|2R_41|2R_42|2R_4 0.00244f
C28 T[2] DAC_OUT 0.52077f
C29 2R_0G|2R_01|2R_02|2R_0 2R_01|2R_02|2R_11|2R_12|2R_1 0
C30 a_18686_8528# a_15326_8528# 0
C31 a_16286_8528# a_14846_8528# 0.00231f
C32 dac_r2r_5_bits_0/dac_sub_r2r_2.net3 dac_r2r_5_bits_0/dac_sub_r2r_2.net1 0.00818f
C33 T[3] DAC_OUT 0.74407f
C34 dac_r2r_5_bits_0/dac_sub_r2r_3.net1 dac_r2r_5_bits_0/dac_sub_r2r_3.net2 0.92498f
C35 a_15326_8528# a_19166_8528# 0
C36 dac_r2r_5_bits_0/dac_sub_r2r_1.net2 dac_r2r_5_bits_0/dac_sub_r2r_1.net3 1.73523f
C37 a_14846_8528# dac_r2r_5_bits_0/dac_sub_r2r_4.net3 0.00161f
C38 B[4] 2R_31|2R_32|2R_41|2R_42|2R_4 0.04645f
C39 2R_21|2R22|2R_31|2R_32|2R_3 2R_31|2R_32|2R_41|2R_42|2R_4 0
C40 dac_r2r_5_bits_0/dac_sub_r2r_1.net3 dac_r2r_5_bits_0/dac_sub_r2r_1.net1 0.00818f
C41 B[2] 2R_21|2R22|2R_31|2R_32|2R_3 0.04647f
C42 dac_r2r_5_bits_0/dac_sub_r2r_0.net3 dac_r2r_5_bits_0/dac_sub_r2r_0.net1 0.00818f
C43 2R_01|2R_02|2R_11|2R_12|2R_1 B[0] 0.04647f
C44 dac_r2r_5_bits_0/dac_sub_r2r_2.net2 dac_r2r_5_bits_0/dac_sub_r2r_2.net3 1.73523f
C45 dac_r2r_5_bits_0/dac_sub_r2r_3.net1 dac_r2r_5_bits_0/dac_sub_r2r_3.net3 0.00818f
C46 T[4] T[5] 0.41433f
C47 2R_11|2R_12|2R_21|2R_22|2R_2 2R_21|2R22|2R_31|2R_32|2R_3 0
C48 a_18686_8528# a_19646_8528# 0.00734f
C49 a_18686_8528# a_14846_8528# 0.18829f
C50 a_15326_8528# a_15806_8528# 1.15162f
C51 dac_r2r_5_bits_0/dac_sub_r2r_1.net2 dac_r2r_5_bits_0/dac_sub_r2r_1.net1 0.92498f
C52 T[0] T[1] 0.41433f
C53 2R_0G|2R_01|2R_02|2R_0 B[0] 0.04645f
C54 T[2] T[1] 0.41433f
C55 a_19166_8528# a_19646_8528# 0.9263f
C56 B[3] 2R_21|2R22|2R_31|2R_32|2R_3 0.04825f
C57 dac_r2r_5_bits_0/dac_sub_r2r_0.net3 2R_0G|2R_0G 0.04634f
C58 dac_r2r_5_bits_0/dac_sub_r2r_4.net3 dac_r2r_5_bits_0/dac_sub_r2r_3.net3 0.15559f
C59 T[6] VGND 1.2037f
C60 T[5] VGND 1.01123f
C61 T[4] VGND 1.157f
C62 T[3] VGND 1.02672f
C63 T[2] VGND 0.95542f
C64 T[1] VGND 0.95542f
C65 T[0] VGND 1.21297f
C66 DAC_OUT VGND 8.04381f
C67 B[4] VGND 1.04666f
C68 B[3] VGND 1.12939f
C69 B[2] VGND 1.13013f
C70 B[1] VGND 1.13013f
C71 B[0] VGND 1.14058f
C72 a_19646_8528# VGND 0.92687f
C73 a_19166_8528# VGND 1.18371f
C74 a_18686_8528# VGND 2.06002f
C75 a_16286_8528# VGND 0.95623f
C76 a_15806_8528# VGND 1.31238f
C77 a_15326_8528# VGND 1.57743f
C78 a_14846_8528# VGND 2.73731f
C79 dac_r2r_5_bits_0/dac_sub_r2r_4.net1 VGND 0.92442f
C80 dac_r2r_5_bits_0/dac_sub_r2r_4.net2 VGND 1.14224f
C81 dac_r2r_5_bits_0/dac_sub_r2r_4.net3 VGND 1.98979f
C82 2R_31|2R_32|2R_41|2R_42|2R_4 VGND 2.74802f
C83 dac_r2r_5_bits_0/dac_sub_r2r_3.net1 VGND 0.92442f
C84 dac_r2r_5_bits_0/dac_sub_r2r_3.net2 VGND 1.14224f
C85 dac_r2r_5_bits_0/dac_sub_r2r_3.net3 VGND 1.84039f
C86 2R_21|2R22|2R_31|2R_32|2R_3 VGND 2.75001f
C87 dac_r2r_5_bits_0/dac_sub_r2r_2.net1 VGND 0.92442f
C88 dac_r2r_5_bits_0/dac_sub_r2r_2.net2 VGND 1.14224f
C89 dac_r2r_5_bits_0/dac_sub_r2r_2.net3 VGND 1.84039f
C90 2R_11|2R_12|2R_21|2R_22|2R_2 VGND 2.74802f
C91 dac_r2r_5_bits_0/dac_sub_r2r_1.net1 VGND 0.92442f
C92 dac_r2r_5_bits_0/dac_sub_r2r_1.net2 VGND 1.14224f
C93 dac_r2r_5_bits_0/dac_sub_r2r_1.net3 VGND 1.84039f
C94 2R_01|2R_02|2R_11|2R_12|2R_1 VGND 2.74802f
C95 dac_r2r_5_bits_0/dac_sub_r2r_0.net1 VGND 0.92442f
C96 dac_r2r_5_bits_0/dac_sub_r2r_0.net2 VGND 1.14224f
C97 dac_r2r_5_bits_0/dac_sub_r2r_0.net3 VGND 1.88344f
C98 2R_0G|2R_01|2R_02|2R_0 VGND 2.24304f
C99 2R_0G|2R_0G VGND 1.12723f
.ends
