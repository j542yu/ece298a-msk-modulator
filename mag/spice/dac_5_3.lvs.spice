* NGSPICE file created from dac_5_3.ext - technology: gf180mcuD

.subckt ppolyf_u_1k_93PAWZ a_n440_4000# a_n440_n4122# a_40_4000# a_40_n4122# VSUBS
X0 a_n440_4000# a_n440_n4122# VSUBS ppolyf_u_1k r_width=2u r_length=40u
X1 a_40_4000# a_40_n4122# VSUBS ppolyf_u_1k r_width=2u r_length=40u
.ends

.subckt ppolyf_u_1k_LP5GLD a_4120_4000# a_n11720_4000# a_n11720_n4122# a_11320_n4122#
+ a_4120_n4122# a_11320_4000# a_n11932_n4334#
X0 a_n11720_4000# a_n11720_n4122# a_n11932_n4334# ppolyf_u_1k r_width=2u r_length=40u
X1 a_11320_4000# a_11320_n4122# a_n11932_n4334# ppolyf_u_1k r_width=2u r_length=40u
X2 a_4120_4000# a_4120_n4122# a_n11932_n4334# ppolyf_u_1k r_width=2u r_length=40u
.ends

.subckt ppolyf_u_1k_932AWZ a_n440_4000# a_1000_n4122# a_n920_n4122# a_n440_n4122#
+ a_n1400_4000# a_40_4000# a_520_n4122# a_1000_4000# a_n920_4000# a_520_4000# a_n1400_n4122#
+ a_40_n4122# VSUBS
X0 a_n1400_4000# a_n1400_n4122# VSUBS ppolyf_u_1k r_width=2u r_length=40u
X1 a_1000_4000# a_1000_n4122# VSUBS ppolyf_u_1k r_width=2u r_length=40u
X2 a_520_4000# a_520_n4122# VSUBS ppolyf_u_1k r_width=2u r_length=40u
X3 a_n440_4000# a_n440_n4122# VSUBS ppolyf_u_1k r_width=2u r_length=40u
X4 a_n920_4000# a_n920_n4122# VSUBS ppolyf_u_1k r_width=2u r_length=40u
X5 a_40_4000# a_40_n4122# VSUBS ppolyf_u_1k r_width=2u r_length=40u
.ends

.subckt dac_sub_therm1 T[4] T[5] T[6] DAC_5_3_OUT VSUBS
Xppolyf_u_1k_932AWZ_0 m1_1149_8361# T[6] DAC_5_3_OUT DAC_5_3_OUT m1_189_8361# m1_1149_8361#
+ T[5] m1_189_8361# m1_669_8361# m1_669_8361# DAC_5_3_OUT T[4] VSUBS ppolyf_u_1k_932AWZ
.ends

.subckt ppolyf_u_1k_9KEAWZ a_n440_4000# a_1480_4000# a_1000_n4122# a_n920_n4122# a_n1880_n4122#
+ a_n440_n4122# a_n1400_4000# a_40_4000# a_520_n4122# a_1480_n4122# a_1000_4000# a_n920_4000#
+ a_n1880_4000# a_520_4000# a_n1400_n4122# a_40_n4122# VSUBS
X0 a_1480_4000# a_1480_n4122# VSUBS ppolyf_u_1k r_width=2u r_length=40u
X1 a_n1400_4000# a_n1400_n4122# VSUBS ppolyf_u_1k r_width=2u r_length=40u
X2 a_1000_4000# a_1000_n4122# VSUBS ppolyf_u_1k r_width=2u r_length=40u
X3 a_n1880_4000# a_n1880_n4122# VSUBS ppolyf_u_1k r_width=2u r_length=40u
X4 a_520_4000# a_520_n4122# VSUBS ppolyf_u_1k r_width=2u r_length=40u
X5 a_n440_4000# a_n440_n4122# VSUBS ppolyf_u_1k r_width=2u r_length=40u
X6 a_n920_4000# a_n920_n4122# VSUBS ppolyf_u_1k r_width=2u r_length=40u
X7 a_40_4000# a_40_n4122# VSUBS ppolyf_u_1k r_width=2u r_length=40u
.ends

.subckt dac_sub_therm2 T[1] T[2] T[3] T[0] DAC_5_3_OUT VSUBS
Xppolyf_u_1k_9KEAWZ_0 m1_1629_8361# m1_189_8361# DAC_5_3_OUT T[2] T[0] T[3] m1_669_8361#
+ m1_1629_8361# DAC_5_3_OUT DAC_5_3_OUT m1_669_8361# m1_1149_8361# m1_189_8361# m1_1149_8361#
+ T[1] DAC_5_3_OUT VSUBS ppolyf_u_1k_9KEAWZ
.ends

.subckt dac_therm_3_bits dac_sub_therm1_0/T[4] dac_sub_therm1_0/T[5] dac_sub_therm1_0/T[6]
+ dac_sub_therm2_0/DAC_5_3_OUT dac_sub_therm2_0/T[0] dac_sub_therm2_0/T[1] dac_sub_therm2_0/T[2]
+ dac_sub_therm2_0/T[3] VSUBS
Xdac_sub_therm1_0 dac_sub_therm1_0/T[4] dac_sub_therm1_0/T[5] dac_sub_therm1_0/T[6]
+ dac_sub_therm2_0/DAC_5_3_OUT VSUBS dac_sub_therm1
Xdac_sub_therm2_0 dac_sub_therm2_0/T[1] dac_sub_therm2_0/T[2] dac_sub_therm2_0/T[3]
+ dac_sub_therm2_0/T[0] dac_sub_therm2_0/DAC_5_3_OUT VSUBS dac_sub_therm2
.ends

.subckt dac_sub_r2r in R_node_out R_node_in VSUBS
Xppolyf_u_1k_932AWZ_0 net1 R_node_out R_node_in R_node_in net3 net1 R_node_out net3
+ net2 net2 R_node_in in VSUBS ppolyf_u_1k_932AWZ
.ends

.subckt dac_r2r_5_bits dac_sub_r2r_2/in dac_sub_r2r_4/in dac_sub_r2r_1/R_node_in dac_sub_r2r_1/in
+ dac_sub_r2r_3/R_node_in dac_sub_r2r_2/R_node_in dac_sub_r2r_3/in dac_sub_r2r_4/R_node_out
+ dac_sub_r2r_0/in dac_sub_r2r_4/R_node_in dac_sub_r2r_0/R_node_in VSUBS
Xdac_sub_r2r_0 dac_sub_r2r_0/in dac_sub_r2r_1/R_node_in dac_sub_r2r_0/R_node_in VSUBS
+ dac_sub_r2r
Xdac_sub_r2r_1 dac_sub_r2r_1/in dac_sub_r2r_2/R_node_in dac_sub_r2r_1/R_node_in VSUBS
+ dac_sub_r2r
Xdac_sub_r2r_2 dac_sub_r2r_2/in dac_sub_r2r_3/R_node_in dac_sub_r2r_2/R_node_in VSUBS
+ dac_sub_r2r
Xdac_sub_r2r_3 dac_sub_r2r_3/in dac_sub_r2r_4/R_node_in dac_sub_r2r_3/R_node_in VSUBS
+ dac_sub_r2r
Xdac_sub_r2r_4 dac_sub_r2r_4/in dac_sub_r2r_4/R_node_out dac_sub_r2r_4/R_node_in VSUBS
+ dac_sub_r2r
.ends

.subckt dac_5_3 B[0] B[1] B[2] B[3] B[4] T[0] T[1] T[2] T[3] T[4] T[5] T[6] DAC_OUT
+ VGND
Xppolyf_u_1k_93PAWZ_0 2R_0G|2R_0G VGND 2R_0G|2R_0G 2R_0G|2R_01|2R_02|2R_0 VGND ppolyf_u_1k_93PAWZ
Xppolyf_u_1k_LP5GLD_0 VGND VGND VGND VGND VGND VGND VGND ppolyf_u_1k_LP5GLD
Xdac_therm_3_bits_0 T[4] T[5] T[6] DAC_OUT T[0] T[1] T[2] T[3] VGND dac_therm_3_bits
Xdac_r2r_5_bits_0 B[2] B[4] 2R_01|2R_02|2R_11|2R_12|2R_1 B[1] 2R_21|2R22|2R_31|2R_32|2R_3
+ 2R_11|2R_12|2R_21|2R_22|2R_2 B[3] DAC_OUT B[0] 2R_31|2R_32|2R_41|2R_42|2R_4 2R_0G|2R_01|2R_02|2R_0
+ VGND dac_r2r_5_bits
.ends
