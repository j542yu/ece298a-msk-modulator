** sch_path: /home/j542yu/Documents/ece298a-msk-modem/xschem/tb_transmit_no_parax.sch
**.subckt tb_transmit_no_parax in enable clk rst_n
*.ipin in
*.ipin enable
*.ipin clk
*.ipin rst_n
V1 net1 GND 3.3
x2 b0 b1 b2 b3 b4 t0 t1 t2 t3 t4 t5 t6 GND net1 clk enable in rst_n tt_um_transmit_5_3_no_parax
**** begin user architecture code

.option wnflag=1

.control
    tran 10n 1us
    write tt_um_transmit_5_3_no_parax.raw
.endc

.include ./stimuli/modulator_5_3_stimuli.spice

.include /usr/local/share/pdk/gf180mcuD/libs.tech/ngspice/design.ngspice
.lib /usr/local/share/pdk/gf180mcuD/libs.tech/ngspice/sm141064.ngspice typical
.lib /usr/local/share/pdk/gf180mcuD/libs.tech/ngspice/sm141064.ngspice res_typical

.model ideal_dac_bridge dac_bridge(out_low=0 out_high=3.3)

a_b0 [b0] [vb0] ideal_dac_bridge
a_b1 [b1] [vb1] ideal_dac_bridge
a_b2 [b2] [vb2] ideal_dac_bridge
a_b3 [b3] [vb3] ideal_dac_bridge
a_b4 [b4] [vb4] ideal_dac_bridge

a_t0 [t0] [vt0] ideal_dac_bridge
a_t1 [t1] [vt1] ideal_dac_bridge
a_t2 [t2] [vt2] ideal_dac_bridge
a_t3 [t3] [vt3] ideal_dac_bridge
a_t4 [t4] [vt4] ideal_dac_bridge
a_t5 [t5] [vt5] ideal_dac_bridge
a_t6 [t6] [vt6] ideal_dac_bridge

Bideal dac_ideal 0 V = (32*(V(vt0)+V(vt1)+V(vt2)+V(vt3)+V(vt4)+V(vt5)+V(vt6)) +
+ V(vb0)+2*V(vb1)+4*V(vb2)+8*V(vb3)+16*V(vb4))/256

**** end user architecture code
**.ends

* expanding   symbol:  tt_um_transmit_5_3_no_parax.sym # of pins=18
** sym_path: /home/j542yu/Documents/ece298a-msk-modem/xschem/tt_um_transmit_5_3_no_parax.sym
.include ../../mag/spice/tt_um_transmit_5_3_no_parax.spice
.GLOBAL GND
.end
