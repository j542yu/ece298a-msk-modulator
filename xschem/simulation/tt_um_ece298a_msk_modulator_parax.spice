** sch_path: /home/j542yu/Documents/ece298a-msk-modem/xschem/tt_um_ece298a_msk_modulator_parax.sym
**.subckt tt_um_ece298a_msk_modulator_parax
**.ends
.end
